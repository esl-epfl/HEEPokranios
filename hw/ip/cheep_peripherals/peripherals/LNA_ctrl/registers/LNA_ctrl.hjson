// Copyright 2026 EPFL contributors
// Solderpad Hardware License, Version 2.1, see LICENSE.md for details.
// SPDX-License-Identifier: Apache-2.0 WITH SHL-2.1
//
// File: LNA_ctrl.hjson
// Author: Juan Sapriza

{
    name: "LNA_ctrl"
    clock_primary: "clk_i"
    reset_primary: "rst_ni"
    bus_interfaces: [
        {
            protocol: "reg_iface"
            direction: "device"
        }
    ]
    regwidth: "32"
    registers: [
        {   name:   "pr"
            desc:     "Pseudo-resistor configuration selection"
            swaccess: "rw"
            hwaccess: "hro"
            resval: "2"
            fields: [
                { bits: "2:0"}
            ]
        }
        {   name:   "gain"
            desc:     "Gain of the LNA amplification selection"
            swaccess: "rw"
            hwaccess: "hro"
            resval: "1"
            fields: [
                { bits: "1:0"}
            ]
        }
        {   name:   "cutoff"
            desc:     "Cutoff frequency selection"
            swaccess: "rw"
            hwaccess: "hro"
            resval: "0"
            fields: [
                { bits: "1:0"}
            ]
        }

    ]
}