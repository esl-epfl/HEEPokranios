// Copyright 2026 EPFL contributors
// Solderpad Hardware License, Version 2.1, see LICENSE.md for details.
// SPDX-License-Identifier: Apache-2.0 WITH SHL-2.1
//
// File: DSM_ctrl.hjson
// Author: Juan Sapriza
// Description: DSM controller

{
    name: "DSM_ctrl"
    clock_primary: "clk_i"
    reset_primary: "rst_ni"
    bus_interfaces: [
        {
            protocol: "reg_iface"
            direction: "device"
        }
    ]
    regwidth: "32"
    registers: [
        { name:   "fsm_en_n"
            desc:     "Enable signal for the FSM. Active LOW."
            swaccess: "rw"
            hwaccess: "hro"
            resval: '0'
            fields: [{ bits: "0:0"}]
        }
        { name:   "resonator_en_n"
            desc:     "Enable signal for the resonator. Active LOW."
            swaccess: "rw"
            hwaccess: "hro"
            resval: '0'
            fields: [{ bits: "0:0"}]
        }
        { name:   "cap_sel"
            desc:     "Capacitor selection"
            swaccess: "rw"
            hwaccess: "hro"
            resval: '0'
            fields: [{ bits: "4:0"}]
        }
        { name:   "lowpower_sel"
            desc:     "Current selection"
            swaccess: "rw"
            hwaccess: "hro"
            resval: '0'
            fields: [{ bits: "1:0"}]
        }
        { name:   "lfp_en"
        desc:     "Enable the LFP mode (instead of the default EAP mode)"
        swaccess: "rw"
        hwaccess: "hro"
        resval:   '0'
        fields: [
                { bits: "0"
                enum: [
                            { value: "0", name: "EAP", desc: "High speed (EAP/broadband) mode"}
                            { value: "1", name: "LFP", desc: "Low speed (LFP) mode"}
                        ]
                }
            ]
        }
        { name:   "out"
            desc:     "Output of the DSM"
            swaccess: "ro"
            hwaccess: "hrw"
            fields: [{ bits: "0:0"}]
        }
   ]
}
