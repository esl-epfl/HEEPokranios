// Copyright 2025 EPFL
// Solderpad Hardware License, Version 2.1, see LICENSE.md for details.
// SPDX-License-Identifier: Apache-2.0 WITH SHL-2.1
//
// Authors: Pierre Guillod <pierre.guillod@epfl.ch>, EPFL, STI-SEL
//          Jérémie Moullet<jeremie.moullet@epfl.ch>,EPFL, STI-SEL
//
// Date: 06.2025

{ name: "CIC_filter"
  clock_primary: "clk_i"
  bus_interfaces: [
    { protocol: "reg_iface", direction: "device" }
  ]
  regwidth: "32"
  registers: [

    // CLOCK DIVISION

    { name:     "CLKDIVIDX"
      desc:     "Decimation ratio from the sys_clk to the sampling frequency"
      swaccess: "rw"
      hwaccess: "hro"
      fields: [
        { bits: "15:0", name: "COUNT", desc: "Index at which clock divide." }
      ]
    }

    // STATUS & CONTROL REGISTERS

    { name:     "CONTROL"
      desc:     "Control register"
      swaccess: "rw"
      hwaccess: "hro"
      fields: [
        { bits: "0", name: "ENABL", desc: "Starts PDM data processing. The FIFO starts to fill with PCM data." }
        { bits: "1", name: "CLEAR", desc: "Clears the FIFO buffer." }
      ]
    }

    { name:     "STATUS"
      desc:     "Status register"
      swaccess: "ro"
      hwaccess: "hrw"
      fields: [
        { bits: "0", name: "EMPTY", desc: "The FIFO buffer is empty." }
        { bits: "1", name: "FULLL", desc: "The FIFO buffer is full."}
      ]
    }

    // CIC Filter stages

    //The maximal number of stage is determined by the number of bits of this field.
    { name:   "cic_activated_stages"
    desc:     "Thermometric value of the activated stages (The 1s should be contiguous and right-aligned)"
      swaccess: "rw"
      hwaccess: "hro"
      fields: [
        { bits: "4:0" }
      ]
    }

    { name:     "cic_delay_comb"
      desc:     "delay in each comb block (D)"
      swaccess: "rw"
      hwaccess: "hro"
      fields: [
        { bits: "1:0" }
      ]
    }

    // DECIMATORS

    { name:     "DECIMCIC"
      desc:     "Samples count after which to decimate in the CIC filter."
      swaccess: "rw"
      hwaccess: "hro"
      fields: [
        { bits: "9:0", name: "COUNT", desc: "Set the samples count" }
      ]
    }

    { name:     "DATA_OUT"
      desc:     "Output sample"
      swaccess: "ro"
      hwaccess: "hrw"
      fields: [
        { bits: "31:0"}
      ]
    }

  ]
}

