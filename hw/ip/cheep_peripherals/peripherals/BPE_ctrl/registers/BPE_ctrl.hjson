// Copyright 2026 EPFL contributors
// Solderpad Hardware License, Version 2.1, see LICENSE.md for details.
// SPDX-License-Identifier: Apache-2.0 WITH SHL-2.1
//
// File: BPE_ctrl.hjson
// Author: Juan Sapriza

{
    name: "BPE_ctrl"
    clock_primary: "clk_i"
    reset_primary: "rst_ni"
    bus_interfaces: [
        {
            protocol: "reg_iface"
            direction: "device"
        }
    ]
    regwidth: "32"
    registers: [
        { name:   "ibias_sel"
        desc:     "Select the bias current"
        swaccess: "rw"
        hwaccess: "hro"
        resval: "7"
        fields: [
            { bits: "5:0"}
           ]
        }
        { name:   "ch_en"
        desc:     "Enable a channel"
        swaccess: "rw"
        hwaccess: "hro"
        resval: "16"
        fields: [
            { bits: "5:0"}
           ]
        }

        ]
}